ADE simulation setup
Run mode: Single Run, Sweeps and Corners
Tests:
  5000myLib:INV1X:1: 5000myLib/INV1X/layout, simulator spectre
